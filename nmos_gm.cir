* NMOS Id-Vgs and gm, SKY130
.lib /foss/pdks/sky130A/libs.tech/ngspice/sky130.lib.spice tt

Vds d 0 1.0
Vgs g 0 0
XM1 d g 0 0 sky130_fd_pr__nfet_01v8 W=1 L=0.5

.control
dc Vgs 0 1.8 0.01
let id = -i(Vds)
let gm = deriv(id)
plot id
plot gm
.endc
.end
